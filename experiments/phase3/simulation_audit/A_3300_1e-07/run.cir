Excitation A; RTN=0 (not PCB local ground)
Iexc sensor 0 DC 0.00055329281934996238
Rout sensor 0 6158.335720423941
Rload sensor 0 3300
Iprobe 0 sensor DC 9.9999999999999995e-08 AC 1
.options reltol=1e-9 abstol=1e-14
.control
set filetype=ascii
op
write op.raw all
ac lin 1 1 1
write ac.raw all
quit
.endc
.end
