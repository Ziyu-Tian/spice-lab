Excitation C; RTN=0 (not PCB local ground)
Bexc sensor 0 I=max(0,0.000464957264957265+min(0,(v(sensor)--0.75365899877899878)/10))
Rload sensor 0 1000000000
Iprobe 0 sensor DC 0 AC 1
.options reltol=1e-9 abstol=1e-14
.control
set filetype=ascii
op
write op.raw all
ac lin 1 1 1
write ac.raw all
quit
.endc
.end
