XSPICE mixed analog/digital Code Model validation: ADC inverter DAC
VIN in 0 PULSE(0 3.3 1u 1n 1n 2u 4u)
AADC [in] [digital_in] adc_test
AINV digital_in digital_out inverter_test
ADAC [digital_out] [out] dac_test
.model adc_test adc_bridge(in_low=0.8 in_high=2)
.model inverter_test d_inverter(rise_delay=10n fall_delay=10n)
.model dac_test dac_bridge(out_low=0 out_high=3.3 out_undef=1.65
+ input_load=1p t_rise=10n t_fall=10n)
RLOAD out 0 1k
.control
set wr_singlescale
set wr_vecnames
set numdgt=15
tran 5n 10u
wrdata digital_inverter.txt v(in) v(out)
quit
.endc
.end
