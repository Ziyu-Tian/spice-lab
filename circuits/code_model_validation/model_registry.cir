Inspect loaded XSPICE Code Model registry
V1 in 0 0
R1 in 0 1k
.control
devhelp
quit
.endc
.end
