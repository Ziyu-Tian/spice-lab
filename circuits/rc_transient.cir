RC step response: 1 kohm, 1 uF, 1 V (tau = 1 ms)
* UIC and IC=0 give a zero-charge capacitor at t=0.
* The DC source is applied at t=0, so there is no finite rise-time correction.
Vstep in 0 DC 1
R1 in out 1k
C1 out 0 1u IC=0
.options reltol=1e-7 abstol=1e-12 vntol=1e-9 method=trap
.tran 2u 8m 0 2u uic
.control
set noaskquit
set wr_singlescale
set wr_vecnames
set numdgt=15
run
wrdata rc_transient_ngspice.txt v(out)
quit
.endc
.end
